* TACT Switch Contact Circuit - Variant B (4.7k pull-up, stronger pull-up for reduced height dome)
V1 VCC 0 DC 5
Rpullup VCC OUT 4.7k
Rcontact OUT 0 1
.end
