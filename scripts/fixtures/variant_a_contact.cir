* TACT Switch Contact Circuit - Variant A (10k pull-up)
V1 VCC 0 DC 5
Rpullup VCC OUT 10k
Rcontact OUT 0 1
.end
