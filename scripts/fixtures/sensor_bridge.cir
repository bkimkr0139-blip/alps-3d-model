* MEMS Pressure Sensor - Piezoresistive Half-Bridge (3V supply, 5k fixed leg)
V1 VCC 0 DC 3.0
Rcontact VCC OUT 4800
Rbridge OUT 0 5000
.end
